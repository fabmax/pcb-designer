op test
V1 in 0 DC 1 AC 1
R1 in out 1k
C1 out 0 1u
.op
.ac dec 2 1 100
.end
